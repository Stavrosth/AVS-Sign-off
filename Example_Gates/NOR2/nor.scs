// Stavros Stathoudakis
simulator lang=spice

.INCLUDE "/CASNFSHOME/home/tsaikaterini/IHP/IHP_Generation_files/130ng/ihp013ng_include_all_slow.scs"
.INCLUDE "/CASNFSHOME/home/tsaikaterini/IHP/IHP_Generation_files/130ng/ixc013ng_stdcell_rc.scs"

.TEMP 0.0
.PARAM VVDVAL=0.96
.PARAM M=3
.PARAM Capacitance=0.5pf
VVDD VDD 0 'VVDVAL'
VGND VSS 0 0.000000
Vin  in1  0  PULSE(0 VVDVAL 5p 150p 150p 1n 2n)

// Chain
ncell1 in10 vss out vdd vss NO2JIX0
ncell2 out0 vss out2 vdd vss NO2JIX0
ncell3 out20 vss out3 vdd vss NO2JIX0
ncell4 out30 vss out4 vdd vss NO2JIX0
ncell5 out40 vss out5 vdd vss NO2JIX0
ncell6 out50 vss out6 vdd vss NO2JIX0
ncell7 out60 vss out7 vdd vss NO2JIX0
ncell8 out70 vss out8 vdd vss NO2JIX0
ncell9 out80 vss out9 vdd vss NO2JIX0
ncell10 out90 vss out10 vdd vss NO2JIX0
// Chain ends

//Gate load starts
.subckt FO4 out vdd vss
ncell11 out vss out11 vdd vss NO2JIX0
ncell12 out vss out12 vdd vss NO2JIX0
ncell13 out vss out13 vdd vss NO2JIX0
.ends FO4

// FO4 instantiation
nfanout4_1 out vdd vss FO4
nfanout4_2 out2 vdd vss FO4
nfanout4_3 out3 vdd vss FO4
nfanout4_4 out4 vdd vss FO4
nfanout4_5 out5 vdd vss FO4
nfanout4_6 out6 vdd vss FO4
nfanout4_7 out7 vdd vss FO4
nfanout4_8 out8 vdd vss FO4
nfanout4_9 out9 vdd vss FO4
nfanout4_10 out10 vdd vss FO4
//Gate load ends

//Wire load starts
.subckt Wire_delay in out
R1 in out 0.315827k
C1 out Capacitance*M
.ends Wire_delay

// Wire_delay RC delays instantiation
X_in1_wire in1 in10 Wire_delay
X_out_wire out out0 Wire_delay
X_out2_wire out2 out20 Wire_delay
X_out3_wire out3 out30 Wire_delay
X_out4_wire out4 out40 Wire_delay
X_out5_wire out5 out50 Wire_delay
X_out6_wire out6 out60 Wire_delay
X_out7_wire out7 out70 Wire_delay
X_out8_wire out8 out80 Wire_delay
X_out9_wire out9 out90 Wire_delay
X_out10_wire out10 out100 Wire_delay
//Wire load ends

.TRAN 1e-13 2e-09

// Measurement of delay
.meas tran delay_out6 when V(out60)='VVDVAL/2' rise=1
.meas tran delay_out8 when V(out80)='VVDVAL/2' rise=1
.meas tran delay_out8_out6 param='(delay_out8 - delay_out6)'

.ALTER
.TEMP 50.0

.ALTER
.TEMP 125.0

//finish
