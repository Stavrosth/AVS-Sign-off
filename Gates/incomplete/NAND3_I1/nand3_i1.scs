// Stavros Stathoudakis
simulator lang=spice

.INCLUDE "/CASNFSHOME/home/tsaikaterini/IHP/IHP_Generation_files/130ng/ihp013ng_include_all_slow.scs"
.INCLUDE "/CASNFSHOME/home/tsaikaterini/IHP/IHP_Generation_files/130ng/ixc013ng_stdcell_rc.scs"

.TEMP 0.0
.PARAM VVDVAL=0.96
VVDD VDD 0 'VVDVAL'
VGND VSS 0 0.000000
Vin  in1  0  PULSE(0 VVDVAL 5p 150p 150p 1n 2n)

// Chain
nand1 in1 vdd vdd out vdd vss NA3I1JIX1
nand2 out0 vdd vdd out2 vdd vss NA3I1JIX1
nand3 out20 vdd vdd out3 vdd vss NA3I1JIX1
nand4 out30 vdd vdd out4 vdd vss NA3I1JIX1
nand5 out40 vdd vdd out5 vdd vss NA3I1JIX1
nand6 out50 vdd vdd out6 vdd vss NA3I1JIX1
nand7 out60 vdd vdd out7 vdd vss NA3I1JIX1
nand8 out70 vdd vdd out8 vdd vss NA3I1JIX1
nand9 out80 vdd vdd out9 vdd vss NA3I1JIX1
nand10 out90 vdd vdd out10 vdd vss NA3I1JIX1

// FO4
.subckt FO4 out vdd vss
nand11 out vdd vdd out11 vdd vss NA3I1JIX1
nand12 out vdd vdd out12 vdd vss NA3I1JIX1
nand13 out vdd vdd out13 vdd vss NA3I1JIX1
nand14 out vdd vdd out14 vdd vss NA3I1JIX1
.ends FO4

nand1_fanout4 out0 vdd vss FO4
nand2_fanout4 out20 vdd vss FO4
nand3_fanout4 out30 vdd vss FO4
nand4_fanout4 out40 vdd vss FO4
nand5_fanout4 out50 vdd vss FO4
nand6_fanout4 out60 vdd vss FO4
nand7_fanout4 out70 vdd vss FO4
nand8_fanout4 out80 vdd vss FO4
nand9_fanout4 out90 vdd vss FO4
nand10_fanout4 out100 vdd vss FO4

// Wire_delay RC delays
.subckt Wire_delay in out
R1 in out 0.315827k
C1 out 0.011918pf
.ends Wire_delay

// Wire_delay RC delays instantiation
X_in1_wire in1 in10 Wire_delay
X_out_wire out out0 Wire_delay
X_out2_wire out2 out20 Wire_delay
X_out3_wire out3 out30 Wire_delay
X_out4_wire out4 out40 Wire_delay
X_out5_wire out5 out50 Wire_delay
X_out6_wire out6 out60 Wire_delay
X_out7_wire out7 out70 Wire_delay
X_out8_wire out8 out80 Wire_delay
X_out9_wire out9 out90 Wire_delay
X_out10_wire out10 out100 Wire_delay

.TRAN 1e-13 1e-08

// Measurement of delay
.meas tran delay_out6 when V(out60)='VVDVAL/2' rise=1
.meas tran delay_out8 when V(out80)='VVDVAL/2' rise=1
.meas tran delay_out8_ou6 param='(delay_out80 - delay_out60)'

.ALTER
.TEMP 50.0

.ALTER
.TEMP 125.0
