// Stavros Stathoudakis
simulator lang=spectre
global 0
include "/CASNFSHOME/home/dvaliantzas/techlibs.srcs/IHP-0.13/SG13S_618_rev1.12.16/tech/SG13_MOS/library/spectre/cornerMOSlv_psp.scs" section=tt
include "/CASNFSHOME/home/dvaliantzas/techlibs.srcs/IHP-0.13/symlinks/ixc013ng_stdcell.RHCharacterisation_latest/transistormodels/ixc013ng_stdcell_rc.scs"

// Chain
nor1 (in1 vdd out vdd vss) EO2JIX0
nor2 (out vdd out2 vdd vss) EO2JIX0
nor3 (out2 vdd out3 vdd vss) EO2JIX0
nor4 (out3 vdd out4 vdd vss) EO2JIX0
nor5 (out4 vdd out5 vdd vss) EO2JIX0
nor6 (out5 vdd out6 vdd vss) EO2JIX0
nor7 (out6 vdd out7 vdd vss) EO2JIX0
nor8 (out7 vdd out8 vdd vss) EO2JIX0
nor9 (out8 vdd out9 vdd vss) EO2JIX0
nor10 (out9 vdd out10 vdd vss) EO2JIX0

// FO4
subckt FO4 (out vdd vss)
nor11 (out vdd out11 vdd vss) EO2JIX0
nor12 (out vdd out12 vdd vss) EO2JIX0
nor13 (out vdd out13 vdd vss) EO2JIX0
ends

nor1_fanout4 (out vdd vss) FO4
nor2_fanout4 (out2 vdd vss) FO4
nor3_fanout4 (out3 vdd vss) FO4
nor4_fanout4 (out4 vdd vss) FO4
nor5_fanout4 (out5 vdd vss) FO4
nor6_fanout4 (out6 vdd vss) FO4
nor7_fanout4 (out7 vdd vss) FO4
nor8_fanout4 (out8 vdd vss) FO4
nor9_fanout4 (out9 vdd vss) FO4
nor10_fanout4 (out10 vdd vss) FO4

// Inputs
_vvss (vss 0) vsource dc=0 type=dc
_vvdd (vdd 0) vsource dc=1.2 type=dc
_vin1 (in1 0) vsource data="01" rptstart=1 rpttimes=0 val1=1.2 val0=0 delay=5p rise=150p fall=150p period=1n type=bit

// Simulation
simulatorOptions options reltol=1e-3 vabstol=1e-6 iabstol=1e-12 temp=27 \
    tnom=27 scalem=1.0 scale=1.0 gmin=1e-12 rforce=1 maxnotes=5 maxwarns=5 \
    digits=5 cols=80 pivrel=1e-3 ckptclock=1800 sensfile="../psf/sens.output" checklimitdest=psf

tran tran stop=5000n write="spectre.ic" writefinal="spectre.fc" annotate=status maxiters=5

// Measurement of delay
simulator lang=spice
.param voltage=1.2
.meas tran delay_out6 when V(out6)='voltage/2' rise=1
.meas tran delay_out8 when V(out8)='voltage/2' rise=1
.meas tran slew20 when V(out2)='voltage*0.2' rise=1
.meas tran slew80 when V(out2)='voltage*0.8' rise=1
.meas tran delay_out8_ou6 param='(delay_out8 - delay_out6)'
.meas tran slew param='(slew80 - slew20)'
