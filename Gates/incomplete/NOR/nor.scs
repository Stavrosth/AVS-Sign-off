// Stavros Stathoudakis
simulator lang=spice

.INCLUDE "/CASNFSHOME/home/tsaikaterini/IHP/IHP_Generation_files/130ng/ihp013ng_include_all_slow.scs"
.INCLUDE "/CASNFSHOME/home/tsaikaterini/IHP/IHP_Generation_files/130ng/ixc013ng_stdcell_rc.scs"

.TEMP 0.0
.PARAM VVDVAL=0.96
VVDD VDD 0 'VVDVAL'
VGND VSS 0 0.000000
Vin  in1  0  PULSE(0 0.96 5p 150p 150p 1n 2n)

// Chain
nor1 in1 vss out vdd vss NO2JIX0
nor2 out vss out2 vdd vss NO2JIX0
nor3 out2 vss out3 vdd vss NO2JIX0
nor4 out3 vss out4 vdd vss NO2JIX0
nor5 out4 vss out5 vdd vss NO2JIX0
nor6 out5 vss out6 vdd vss NO2JIX0
nor7 out6 vss out7 vdd vss NO2JIX0
nor8 out7 vss out8 vdd vss NO2JIX0
nor9 out8 vss out9 vdd vss NO2JIX0
nor10 out9 vss out10 vdd vss NO2JIX0

// FO4
.subckt FO4 out vdd vss
nor11 out vss out11 vdd vss NO2JIX0
nor12 out vss out12 vdd vss NO2JIX0
nor13 out vss out13 vdd vss NO2JIX0
.ends FO4

nor1_fanout4 out vdd vss FO4
nor2_fanout4 out2 vdd vss FO4
nor3_fanout4 out3 vdd vss FO4
nor4_fanout4 out4 vdd vss FO4
nor5_fanout4 out5 vdd vss FO4
nor6_fanout4 out6 vdd vss FO4
nor7_fanout4 out7 vdd vss FO4
nor8_fanout4 out8 vdd vss FO4
nor9_fanout4 out9 vdd vss FO4
nor10_fanout4 out10 vdd vss FO4

.TRAN 1e-13 1e-08

// Measurement of delay
.meas tran delay_out6 when V(out6)='VVDVAL/2' rise=1
.meas tran delay_out8 when V(out8)='VVDVAL/2' rise=1
.meas tran delay_out8_ou6 param='(delay_out8 - delay_out6)'

.ALTER
.TEMP 50.0

.ALTER
.TEMP 125.0
