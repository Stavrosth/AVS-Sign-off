// Stavros Stathoudakis
simulator lang=spice

.INCLUDE "/CASNFSHOME/home/tsaikaterini/IHP/IHP_Generation_files/130ng/ihp013ng_include_all_slow.scs"
.INCLUDE "/CASNFSHOME/home/tsaikaterini/IHP/IHP_Generation_files/130ng/ixc013ng_stdcell_rc.scs"

.TEMP 0.0
.PARAM VVDVAL=0.96
VVDD VDD 0 'VVDVAL'
VGND VSS 0 0.000000
Vin  in1  0  PULSE(0 VVDVAL 5p 150p 150p 1n 2n)

// Chain
//MU4JIX2 IN0 IN1 IN2 IN3 Q VDD VSS S0 S1
mu1 in10 vss vss vss out vdd vss vss vss MU4JIX2
mu2 out0 vss vss vss out2 vdd vss vss vss MU4JIX2
mu3 out20 vss vss vss out3 vdd vss vss vss MU4JIX2
mu4 out30 vss vss vss out4 vdd vss vss vss MU4JIX2
mu5 out40 vss vss vss out5 vdd vss vss vss MU4JIX2
mu6 out50 vss vss vss out6 vdd vss vss vss MU4JIX2
mu7 out60 vss vss vss out7 vdd vss vss vss MU4JIX2
mu8 out70 vss vss vss out8 vdd vss vss vss MU4JIX2
mu9 out80 vss vss vss out9 vdd vss vss vss MU4JIX2
mu10 out90 vss vss vss out10 vdd vss vss vss MU4JIX2

// FO4
.subckt FO4 out vdd vss
mu11 out vss vss vss out11 vdd vss vss vss MU4JIX2
mu12 out vss vss vss out12 vdd vss vss vss MU4JIX2
mu13 out vss vss vss out13 vdd vss vss vss MU4JIX2
mu14 out vss vss vss out14 vdd vss vss vss MU4JIX2
.ends FO4

mu1_fanout4 out0 vdd vss FO4
mu2_fanout4 out20 vdd vss FO4
mu3_fanout4 out30 vdd vss FO4
mu4_fanout4 out40 vdd vss FO4
mu5_fanout4 out50 vdd vss FO4
mu6_fanout4 out60 vdd vss FO4
mu7_fanout4 out70 vdd vss FO4
mu8_fanout4 out80 vdd vss FO4
mu9_fanout4 out90 vdd vss FO4
mu10_fanout4 out100 vdd vss FO4

// Wire_delay RC delays
.subckt Wire_delay in out
R1 in out 0.315827k
C1 out 0.011918pf
.ends Wire_delay

// Wire_delay RC delays instantiation
X_in1_wire in1 in10 Wire_delay
X_out_wire out out0 Wire_delay
X_out2_wire out2 out20 Wire_delay
X_out3_wire out3 out30 Wire_delay
X_out4_wire out4 out40 Wire_delay
X_out5_wire out5 out50 Wire_delay
X_out6_wire out6 out60 Wire_delay
X_out7_wire out7 out70 Wire_delay
X_out8_wire out8 out80 Wire_delay
X_out9_wire out9 out90 Wire_delay
X_out10_wire out10 out100 Wire_delay

.TRAN 1e-13 1e-08

// Measurement of delay
.meas tran delay_out6 when V(out60)='VVDVAL/2' rise=1
.meas tran delay_out8 when V(out80)='VVDVAL/2' rise=1
.meas tran delay_out8_ou6 param='(delay_out8 - delay_out6)'

.ALTER
.TEMP 50.0

.ALTER
.TEMP 125.0
